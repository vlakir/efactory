* 12AX7 — Duncan fit (альтернатива Koren-fit'у в koren/12AX7.lib).
*
* Те же Koren equations, но параметры из Duncan/Cigna collection.
* Полезно для сравнения «какой fit ближе к моему экземпляру».
* tube_type: triode
* Pins: P (plate), G (grid), K (cathode).
.SUBCKT 12AX7_DUNCAN P G K
* Duncan/Cigna parameters: MU=103 EX=1.453 KG1=613 KP=525 KVB=300
E1 7 0 VALUE={V(P,K)/525*LN(1+EXP(525*(1/103+V(G,K)/SQRT(300+V(P,K)*V(P,K)))))}
G1 P K VALUE={(PWRS(V(7),1.453)+PWRS(V(7),1.453))/613}
C1 G K 1.6p
C2 G P 1.7p
C3 P K 0.46p
RGI G K 1MEG
.ENDS 12AX7_DUNCAN
